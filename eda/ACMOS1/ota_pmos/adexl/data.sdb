ADE simulation setup
Run mode: Single Run, Sweeps and Corners
Tests:
  ACMOS1:tb_ota_pmos_stb:1: ACMOS1/tb_ota_pmos_stb/schematic, simulator spectre
  ACMOS1:tb_ota_ACMOS1:tb_ota_pmosACMOS1:tb_ota_pmos_trans:1_tr...pmosACMOS1:tb_ota_pmos_trans:1_trans:1 (off): ACMOS1/tb_ota_pmos_trans/schematic, simulator spectre
Global variables:
  cc = 150f
  cl = 200f
  rc = 7K
  vcm = 0.4
Specs:
  ACMOS1:tb_ota_pmos_stb:1 / Low Frequency Gain: > 54
  ACMOS1:tb_ota_pmos_stb:1 / Unity Gain Phase Margin: > 60
  ACMOS1:tb_ota_pmos_stb:1 / Unity Gain Frequency: > 220M
  ACMOS1:tb_ota_ACMOS1:tb_ota_pmosACMOS1:tb_ota_pmos_trans:1_tr...pmosACMOS1:tb_ota_pmos_trans:1_trans:1 / Spectrum SINAD: > 40
