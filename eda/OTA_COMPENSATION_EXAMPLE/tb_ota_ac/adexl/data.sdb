ADE simulation setup
Run mode: Single Run, Sweeps and Corners
Tests:
  OTA_COMPENSATION_EXAMPLE:tb_ota_ac:1: OTA_COMPENSATION_EXAMPLE/tb_ota_ac/schematic, simulator spectre
Global variables:
  cc = 300f
  rc = 3k
  vdd = 1
