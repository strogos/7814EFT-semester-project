ADE simulation setup
Run mode: Single Run, Sweeps and Corners
Tests:
  OTA_COMPENSATION_EXAMPLE:tb_ota_closed_loop:1 (off): OTA_COMPENSATION_EXAMPLE/tb_ota_closed_loop/schematic, simulator spectre
  OTA_COMPENSATION_EXAMPLE:tb_ota_ac:1: OTA_COMPENSATION_EXAMPLE/tb_ota_ac/schematic, simulator spectre
  OTA_COMPENSATION_EXAMPLE:tb_ota_tran:1 (off): OTA_COMPENSATION_EXAMPLE/tb_ota_tran/schematic, simulator spectre
  OTA_COMPENSATION_EXAMPLE:tb_ota_closed_loop:DC (off): OTA_COMPENSATION_EXAMPLE/tb_ota_closed_loop/schematic, simulator spectre
Global variables:
  cl = 450f
  rc = 10M
  cc = .22*cl
  vdd = 1
  vcm = 500m
  vdc_sweep = 0
  I_bias = 20u
  vin_sig = 250m
