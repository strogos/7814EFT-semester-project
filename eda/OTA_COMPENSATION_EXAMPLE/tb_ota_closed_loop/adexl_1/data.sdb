ADE simulation setup
Run mode: Single Run, Sweeps and Corners
Tests:
  tb_ota_closed_loop:DC: OTA_COMPENSATION_EXAMPLE/tb_ota_closed_loop/schematic, simulator spectre
  tb_ota_closed_loop:stb: OTA_COMPENSATION_EXAMPLE/tb_ota_closed_loop/schematic, simulator spectre
  tb_ota_unity_loop:UGF: OTA_COMPENSATION_EXAMPLE/tb_ota_unity_loop/schematic, simulator spectre
  tb_ota_tran:spectrum: OTA_COMPENSATION_EXAMPLE/tb_ota_tran/schematic, simulator spectre
  tb_ota_tran_pulse:1 (off): OTA_COMPENSATION_EXAMPLE/tb_ota_tran_pulse/schematic, simulator spectre
  OTA_COMPENSATION_EXAMPLE:tb_ota_phase_margin:1 (off): OTA_COMPENSATION_EXAMPLE/tb_ota_phase_margin/schematic, simulator spectre
Global variables:
  cl = 140f
  rc = 6.5k
  cc = 45f
  vdd = 1
  vcm = 530m
  vdc_sweep = 0
  I_bias = 20u
  vin_sig = 250m
  vrc_bias = 14m
  voff = 315m
Specs:
  tb_ota_tran:spectrum / tran-spectrum_sinad: > 40
  tb_ota_closed_loop:stb / stb-unity-gain-freq-NOT-UNITY-GAIN-cap-loop-freq: info
  tb_ota_closed_loop:stb / stb-phase-margin-NOT-UNITY-GAIN-cap-loop-freq: > 60
  tb_ota_closed_loop:DC / total-gain-dB: > 54
  tb_ota_closed_loop:DC / dc-POWER-DISSIPIATION: info
  tb_ota_unity_loop:UGF / stb-unity-gain-freq: > 220M
