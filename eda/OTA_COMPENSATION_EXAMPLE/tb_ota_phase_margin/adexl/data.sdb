ADE simulation setup
Run mode: Single Run, Sweeps and Corners
Tests:
  test1: OTA_COMPENSATION_EXAMPLE/tb_ota_phase_margin/schematic, simulator spectre
    Outputs: (- phase(getData("loopGain" ?result "stb")))
